ADE simulation setup
Run mode: Single Run, Sweeps and Corners
Tests:
  VLSI_BitsAndGiggles:PiModel_Full_BG:2: VLSI_BitsAndGiggles/PiModel_Full_BG/schematic, simulator spectre
Corners (nominal off):
  model folders: /app/lib/freepdk45/trunk/ncsu_basekit/models/hspice/tran_models/models_ss
  SS: PMOS_VTL.inc, NMOS_VTL.inc
