ADE simulation setup
Run mode: Single Run, Sweeps and Corners
Tests:
  VLSI_BitsAndGiggles:PiModel_Full_BG_Will:1: VLSI_BitsAndGiggles/PiModel_Full_BG_Will/schematic, simulator spectre
    Outputs: /dataOut<31:0>; /Din<31:0>; /ADDR<6:1>
Global variables:
  T = 1n:10n:101n (off)
  Vin = 1.1
  t = 200n
Corners (nominal off):
  model folders: /app/lib/freepdk45/trunk/ncsu_basekit/models/hspice/tran_models/models_ff, /app/lib/freepdk45/trunk/ncsu_basekit/models/hspice/tran_models/models_nom, /app/lib/freepdk45/trunk/ncsu_basekit/models/hspice/tran_models/models_ss
  TT (off): NMOS_VTH.inc, NMOS_VTL.inc, PMOS_VTH.inc, PMOS_VTL.inc
  FF (off): NMOS_VTH.inc, NMOS_VTL.inc, PMOS_VTH.inc, PMOS_VTL.inc
  SS (off): NMOS_VTH.inc, NMOS_VTL.inc, PMOS_VTH.inc, PMOS_VTL.inc
  SF: PMOS_VTH.inc, PMOS_VTL.inc, NMOS_VTH.inc, NMOS_VTL.inc
  FS (off): NMOS_VTH.inc, NMOS_VTL.inc, PMOS_VTH.inc, PMOS_VTL.inc
