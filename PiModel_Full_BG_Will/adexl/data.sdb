ADE simulation setup
Run mode: Single Run, Sweeps and Corners
Tests:
  VLSI_BitsAndGiggles:PiModel_Full_BG_Will:1: VLSI_BitsAndGiggles/PiModel_Full_BG_Will/schematic, simulator spectre
    Outputs: /dataOut<31:0>; /Din<31:0>; /ADDR<6:1>
Global variables:
  T = 1n:10n:101n (off)
  Vin = 1.1
  t = {From/To}Auto:1n:5:10n{From/To}
