ADE simulation setup
Run mode: Single Run, Sweeps and Corners
Tests:
  VLSI_BitsAndGiggles:8T_Bitcell_Butterfly_BG:1: VLSI_BitsAndGiggles/8T_Bitcell_Butterfly_BG/schematic, simulator spectre
Global variables:
  vdin = 0
Corners (nominal off):
  model folders: /app/lib/freepdk45/trunk/ncsu_basekit/models/hspice/tran_models/models_ff, /app/lib/freepdk45/trunk/ncsu_basekit/models/hspice/tran_models/models_nom, /app/lib/freepdk45/trunk/ncsu_basekit/models/hspice/tran_models/models_ss
  TT: NMOS_VTL.inc, PMOS_VTL.inc
  FF: PMOS_VTL.inc, NMOS_VTL.inc
  SS: NMOS_VTL.inc, PMOS_VTL.inc
  FS: NMOS_VTL.inc, PMOS_VTL.inc
  SF: PMOS_VTL.inc, NMOS_VTL.inc
